* Diode clipper + RC smoothing: nonlinear transient
Vin in 0 SIN(0 5 1k)
R1 in a 1k
D1 a 0 D1N4148
D2 0 a D1N4148
R2 a out 10k
C1 out 0 10n
.model D1N4148 D(Is=2.52n Rs=0.568 N=1.752 Cjo=4p M=0.4 tt=20n)
.control
  tran 2u 5m
  wrdata clipper_out.csv v(in) v(a) v(out)
  meas tran vmax MAX v(a)
  meas tran vmin MIN v(a)
.endc
.end
